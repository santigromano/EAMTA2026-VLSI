* Extracted by KLayout with SG13G2 LVS runset on : 19/03/2026 00:11

.SUBCKT and2
M$1 \$1 \$3 \$4 \$1 sg13_lv_nmos L=0.15u W=0.75u AS=0.255p AD=0.255p PS=2.18u
+ PD=2.18u
M$2 \$1 \$5 \$2 \$1 sg13_lv_nmos L=0.15u W=1.5u AS=0.51p AD=0.285p PS=3.68u
+ PD=1.88u
M$3 \$2 \$6 \$3 \$1 sg13_lv_nmos L=0.15u W=1.5u AS=0.285p AD=0.51p PS=1.88u
+ PD=3.68u
M$4 \$7 \$5 \$3 \$7 sg13_lv_pmos L=0.15u W=1.5u AS=0.51p AD=0.285p PS=3.68u
+ PD=1.88u
M$5 \$3 \$6 \$7 \$7 sg13_lv_pmos L=0.15u W=1.5u AS=0.285p AD=0.51p PS=1.88u
+ PD=3.68u
M$6 \$7 \$3 \$4 \$7 sg13_lv_pmos L=0.15u W=1.5u AS=0.51p AD=0.51p PS=3.68u
+ PD=3.68u
.ENDS and2
