* Extracted by KLayout with SG13G2 LVS runset on : 17/03/2026 21:44

.SUBCKT and2
M$1 \$3 \$9 \$4 \$1 sg13_lv_nmos L=0.15u W=1.5u AS=0.51p AD=0.285p PS=3.68u
+ PD=1.88u
M$2 \$4 \$10 \$5 \$1 sg13_lv_nmos L=0.15u W=1.5u AS=0.285p AD=0.51p PS=1.88u
+ PD=3.68u
M$3 \$6 \$9 \$7 \$2 sg13_lv_pmos L=0.15u W=1.5u AS=0.51p AD=0.285p PS=3.68u
+ PD=1.88u
M$4 \$7 \$10 \$8 \$2 sg13_lv_pmos L=0.15u W=1.5u AS=0.285p AD=0.51p PS=1.88u
+ PD=3.68u
.ENDS and2
