* Extracted by KLayout with SG13G2 LVS runset on : 28/03/2026 20:48

.SUBCKT Contador4bits_U
M$1 \$1 \$5 \$19 \$1 sg13_lv_nmos L=0.15u W=1.5u AS=0.51p AD=0.285p PS=3.68u
+ PD=1.88u
M$2 \$19 \$18 \$6 \$1 sg13_lv_nmos L=0.15u W=1.5u AS=0.285p AD=0.51p PS=1.88u
+ PD=3.68u
M$3 \$1 \$9 \$5 \$1 sg13_lv_nmos L=0.15u W=0.75u AS=0.255p AD=0.1425p PS=2.18u
+ PD=1.13u
M$4 \$5 \$24 \$1 \$1 sg13_lv_nmos L=0.15u W=0.75u AS=0.1425p AD=0.255p PS=1.13u
+ PD=2.18u
M$5 \$1 \$6 \$3 \$1 sg13_lv_nmos L=0.15u W=0.75u AS=0.255p AD=0.255p PS=2.18u
+ PD=2.18u
M$6 \$7 \$20 \$1 \$1 sg13_lv_nmos L=0.15u W=0.75u AS=0.255p AD=0.255p PS=2.18u
+ PD=2.18u
M$7 \$7 \$4 \$9 \$1 sg13_lv_nmos L=0.15u W=0.75u AS=0.255p AD=0.255p PS=2.18u
+ PD=2.18u
M$8 \$9 \$8 \$11 \$1 sg13_lv_nmos L=0.15u W=0.75u AS=0.255p AD=0.255p PS=2.18u
+ PD=2.18u
M$9 \$1 \$5 \$33 \$1 sg13_lv_nmos L=0.15u W=1.5u AS=0.51p AD=0.285p PS=3.68u
+ PD=1.88u
M$10 \$33 \$18 \$34 \$1 sg13_lv_nmos L=0.15u W=1.5u AS=0.285p AD=0.285p
+ PS=1.88u PD=1.88u
M$11 \$34 \$46 \$35 \$1 sg13_lv_nmos L=0.15u W=1.5u AS=0.285p AD=0.285p
+ PS=1.88u PD=1.88u
M$12 \$35 \$36 \$1 \$1 sg13_lv_nmos L=0.15u W=1.5u AS=0.285p AD=0.51p PS=1.88u
+ PD=3.68u
M$13 \$36 \$5 \$1 \$1 sg13_lv_nmos L=0.15u W=0.75u AS=0.255p AD=0.1425p
+ PS=2.18u PD=1.13u
M$14 \$1 \$18 \$46 \$1 sg13_lv_nmos L=0.15u W=0.75u AS=0.1425p AD=0.255p
+ PS=1.13u PD=2.18u
M$15 \$1 \$8 \$4 \$1 sg13_lv_nmos L=0.15u W=0.75u AS=0.255p AD=0.255p PS=2.18u
+ PD=2.18u
M$16 \$34 \$8 \$20 \$1 sg13_lv_nmos L=0.15u W=0.75u AS=0.255p AD=0.255p
+ PS=2.18u PD=2.18u
M$17 \$20 \$4 \$37 \$1 sg13_lv_nmos L=0.15u W=0.75u AS=0.255p AD=0.255p
+ PS=2.18u PD=2.18u
M$18 \$1 \$5 \$11 \$1 sg13_lv_nmos L=0.15u W=0.75u AS=0.255p AD=0.255p PS=2.18u
+ PD=2.18u
M$19 \$1 \$74 \$85 \$1 sg13_lv_nmos L=0.15u W=1.5u AS=0.51p AD=0.285p PS=3.68u
+ PD=1.88u
M$20 \$85 \$72 \$68 \$1 sg13_lv_nmos L=0.15u W=1.5u AS=0.285p AD=0.51p PS=1.88u
+ PD=3.68u
M$21 \$1 \$68 \$18 \$1 sg13_lv_nmos L=0.15u W=0.75u AS=0.255p AD=0.255p
+ PS=2.18u PD=2.18u
M$22 \$69 \$73 \$1 \$1 sg13_lv_nmos L=0.15u W=0.75u AS=0.255p AD=0.255p
+ PS=2.18u PD=2.18u
M$23 \$69 \$67 \$70 \$1 sg13_lv_nmos L=0.15u W=0.75u AS=0.255p AD=0.255p
+ PS=2.18u PD=2.18u
M$24 \$1 \$7 \$37 \$1 sg13_lv_nmos L=0.15u W=0.75u AS=0.255p AD=0.1425p
+ PS=2.18u PD=1.13u
M$25 \$37 \$24 \$1 \$1 sg13_lv_nmos L=0.15u W=0.75u AS=0.1425p AD=0.255p
+ PS=1.13u PD=2.18u
M$26 \$1 \$70 \$74 \$1 sg13_lv_nmos L=0.15u W=0.75u AS=0.255p AD=0.1425p
+ PS=2.18u PD=1.13u
M$27 \$74 \$24 \$1 \$1 sg13_lv_nmos L=0.15u W=0.75u AS=0.1425p AD=0.255p
+ PS=1.13u PD=2.18u
M$28 \$70 \$8 \$71 \$1 sg13_lv_nmos L=0.15u W=0.75u AS=0.255p AD=0.255p
+ PS=2.18u PD=2.18u
M$29 \$1 \$74 \$94 \$1 sg13_lv_nmos L=0.15u W=1.5u AS=0.51p AD=0.285p PS=3.68u
+ PD=1.88u
M$30 \$94 \$72 \$97 \$1 sg13_lv_nmos L=0.15u W=1.5u AS=0.285p AD=0.285p
+ PS=1.88u PD=1.88u
M$31 \$97 \$111 \$95 \$1 sg13_lv_nmos L=0.15u W=1.5u AS=0.285p AD=0.285p
+ PS=1.88u PD=1.88u
M$32 \$95 \$96 \$1 \$1 sg13_lv_nmos L=0.15u W=1.5u AS=0.285p AD=0.51p PS=1.88u
+ PD=3.68u
M$33 \$96 \$74 \$1 \$1 sg13_lv_nmos L=0.15u W=0.75u AS=0.255p AD=0.1425p
+ PS=2.18u PD=1.13u
M$34 \$1 \$72 \$111 \$1 sg13_lv_nmos L=0.15u W=0.75u AS=0.1425p AD=0.255p
+ PS=1.13u PD=2.18u
M$35 \$1 \$8 \$67 \$1 sg13_lv_nmos L=0.15u W=0.75u AS=0.255p AD=0.255p PS=2.18u
+ PD=2.18u
M$36 \$97 \$8 \$73 \$1 sg13_lv_nmos L=0.15u W=0.75u AS=0.255p AD=0.255p
+ PS=2.18u PD=2.18u
M$37 \$73 \$67 \$98 \$1 sg13_lv_nmos L=0.15u W=0.75u AS=0.255p AD=0.255p
+ PS=2.18u PD=2.18u
M$38 \$1 \$74 \$71 \$1 sg13_lv_nmos L=0.15u W=0.75u AS=0.255p AD=0.255p
+ PS=2.18u PD=2.18u
M$39 \$1 \$129 \$145 \$1 sg13_lv_nmos L=0.15u W=1.5u AS=0.51p AD=0.285p
+ PS=3.68u PD=1.88u
M$40 \$145 \$144 \$130 \$1 sg13_lv_nmos L=0.15u W=1.5u AS=0.285p AD=0.51p
+ PS=1.88u PD=3.68u
M$41 \$1 \$130 \$72 \$1 sg13_lv_nmos L=0.15u W=0.75u AS=0.255p AD=0.255p
+ PS=2.18u PD=2.18u
M$42 \$131 \$146 \$1 \$1 sg13_lv_nmos L=0.15u W=0.75u AS=0.255p AD=0.255p
+ PS=2.18u PD=2.18u
M$43 \$131 \$128 \$132 \$1 sg13_lv_nmos L=0.15u W=0.75u AS=0.255p AD=0.255p
+ PS=2.18u PD=2.18u
M$44 \$1 \$69 \$98 \$1 sg13_lv_nmos L=0.15u W=0.75u AS=0.255p AD=0.1425p
+ PS=2.18u PD=1.13u
M$45 \$98 \$24 \$1 \$1 sg13_lv_nmos L=0.15u W=0.75u AS=0.1425p AD=0.255p
+ PS=1.13u PD=2.18u
M$46 \$1 \$132 \$129 \$1 sg13_lv_nmos L=0.15u W=0.75u AS=0.255p AD=0.1425p
+ PS=2.18u PD=1.13u
M$47 \$129 \$24 \$1 \$1 sg13_lv_nmos L=0.15u W=0.75u AS=0.1425p AD=0.255p
+ PS=1.13u PD=2.18u
M$48 \$132 \$8 \$133 \$1 sg13_lv_nmos L=0.15u W=0.75u AS=0.255p AD=0.255p
+ PS=2.18u PD=2.18u
M$49 \$1 \$129 \$155 \$1 sg13_lv_nmos L=0.15u W=1.5u AS=0.51p AD=0.285p
+ PS=3.68u PD=1.88u
M$50 \$155 \$144 \$156 \$1 sg13_lv_nmos L=0.15u W=1.5u AS=0.285p AD=0.285p
+ PS=1.88u PD=1.88u
M$51 \$156 \$168 \$157 \$1 sg13_lv_nmos L=0.15u W=1.5u AS=0.285p AD=0.285p
+ PS=1.88u PD=1.88u
M$52 \$157 \$158 \$1 \$1 sg13_lv_nmos L=0.15u W=1.5u AS=0.285p AD=0.51p
+ PS=1.88u PD=3.68u
M$53 \$158 \$129 \$1 \$1 sg13_lv_nmos L=0.15u W=0.75u AS=0.255p AD=0.1425p
+ PS=2.18u PD=1.13u
M$54 \$1 \$144 \$168 \$1 sg13_lv_nmos L=0.15u W=0.75u AS=0.1425p AD=0.255p
+ PS=1.13u PD=2.18u
M$55 \$1 \$8 \$128 \$1 sg13_lv_nmos L=0.15u W=0.75u AS=0.255p AD=0.255p
+ PS=2.18u PD=2.18u
M$56 \$156 \$8 \$146 \$1 sg13_lv_nmos L=0.15u W=0.75u AS=0.255p AD=0.255p
+ PS=2.18u PD=2.18u
M$57 \$146 \$128 \$159 \$1 sg13_lv_nmos L=0.15u W=0.75u AS=0.255p AD=0.255p
+ PS=2.18u PD=2.18u
M$58 \$1 \$129 \$133 \$1 sg13_lv_nmos L=0.15u W=0.75u AS=0.255p AD=0.255p
+ PS=2.18u PD=2.18u
M$59 \$1 \$190 \$207 \$1 sg13_lv_nmos L=0.15u W=1.5u AS=0.51p AD=0.285p
+ PS=3.68u PD=1.88u
M$60 \$207 \$202 \$191 \$1 sg13_lv_nmos L=0.15u W=1.5u AS=0.285p AD=0.51p
+ PS=1.88u PD=3.68u
M$61 \$1 \$191 \$144 \$1 sg13_lv_nmos L=0.15u W=0.75u AS=0.255p AD=0.255p
+ PS=2.18u PD=2.18u
M$62 \$192 \$203 \$1 \$1 sg13_lv_nmos L=0.15u W=0.75u AS=0.255p AD=0.255p
+ PS=2.18u PD=2.18u
M$63 \$192 \$189 \$193 \$1 sg13_lv_nmos L=0.15u W=0.75u AS=0.255p AD=0.255p
+ PS=2.18u PD=2.18u
M$64 \$1 \$131 \$159 \$1 sg13_lv_nmos L=0.15u W=0.75u AS=0.255p AD=0.1425p
+ PS=2.18u PD=1.13u
M$65 \$159 \$24 \$1 \$1 sg13_lv_nmos L=0.15u W=0.75u AS=0.1425p AD=0.255p
+ PS=1.13u PD=2.18u
M$66 \$1 \$193 \$190 \$1 sg13_lv_nmos L=0.15u W=0.75u AS=0.255p AD=0.1425p
+ PS=2.18u PD=1.13u
M$67 \$190 \$24 \$1 \$1 sg13_lv_nmos L=0.15u W=0.75u AS=0.1425p AD=0.255p
+ PS=1.13u PD=2.18u
M$68 \$193 \$8 \$195 \$1 sg13_lv_nmos L=0.15u W=0.75u AS=0.255p AD=0.255p
+ PS=2.18u PD=2.18u
M$69 \$1 \$190 \$216 \$1 sg13_lv_nmos L=0.15u W=1.5u AS=0.51p AD=0.285p
+ PS=3.68u PD=1.88u
M$70 \$216 \$202 \$217 \$1 sg13_lv_nmos L=0.15u W=1.5u AS=0.285p AD=0.285p
+ PS=1.88u PD=1.88u
M$71 \$217 \$234 \$218 \$1 sg13_lv_nmos L=0.15u W=1.5u AS=0.285p AD=0.285p
+ PS=1.88u PD=1.88u
M$72 \$218 \$219 \$1 \$1 sg13_lv_nmos L=0.15u W=1.5u AS=0.285p AD=0.51p
+ PS=1.88u PD=3.68u
M$73 \$219 \$190 \$1 \$1 sg13_lv_nmos L=0.15u W=0.75u AS=0.255p AD=0.1425p
+ PS=2.18u PD=1.13u
M$74 \$1 \$202 \$234 \$1 sg13_lv_nmos L=0.15u W=0.75u AS=0.1425p AD=0.255p
+ PS=1.13u PD=2.18u
M$75 \$1 \$8 \$189 \$1 sg13_lv_nmos L=0.15u W=0.75u AS=0.255p AD=0.255p
+ PS=2.18u PD=2.18u
M$76 \$217 \$8 \$203 \$1 sg13_lv_nmos L=0.15u W=0.75u AS=0.255p AD=0.255p
+ PS=2.18u PD=2.18u
M$77 \$203 \$189 \$220 \$1 sg13_lv_nmos L=0.15u W=0.75u AS=0.255p AD=0.255p
+ PS=2.18u PD=2.18u
M$78 \$1 \$190 \$195 \$1 sg13_lv_nmos L=0.15u W=0.75u AS=0.255p AD=0.255p
+ PS=2.18u PD=2.18u
M$79 \$1 \$192 \$220 \$1 sg13_lv_nmos L=0.15u W=0.75u AS=0.255p AD=0.1425p
+ PS=2.18u PD=1.13u
M$80 \$220 \$24 \$1 \$1 sg13_lv_nmos L=0.15u W=0.75u AS=0.1425p AD=0.255p
+ PS=1.13u PD=2.18u
M$81 \$2 \$5 \$6 \$2 sg13_lv_pmos L=0.15u W=1.5u AS=0.51p AD=0.285p PS=3.68u
+ PD=1.88u
M$82 \$6 \$18 \$2 \$2 sg13_lv_pmos L=0.15u W=1.5u AS=0.285p AD=0.51p PS=1.88u
+ PD=3.68u
M$83 \$2 \$6 \$3 \$2 sg13_lv_pmos L=0.15u W=1.5u AS=0.51p AD=0.51p PS=3.68u
+ PD=3.68u
M$84 \$7 \$20 \$2 \$2 sg13_lv_pmos L=0.15u W=1.5u AS=0.51p AD=0.51p PS=3.68u
+ PD=3.68u
M$85 \$10 \$24 \$2 \$2 sg13_lv_pmos L=0.15u W=3u AS=0.795p AD=0.795p PS=5.56u
+ PD=5.56u
M$87 \$7 \$8 \$9 \$2 sg13_lv_pmos L=0.15u W=1.5u AS=0.51p AD=0.51p PS=3.68u
+ PD=3.68u
M$88 \$5 \$9 \$10 \$2 sg13_lv_pmos L=0.15u W=3u AS=0.795p AD=0.795p PS=5.56u
+ PD=5.56u
M$90 \$37 \$24 \$47 \$2 sg13_lv_pmos L=0.15u W=3u AS=0.795p AD=0.795p PS=5.56u
+ PD=5.56u
M$92 \$9 \$4 \$11 \$2 sg13_lv_pmos L=0.15u W=1.5u AS=0.51p AD=0.51p PS=3.68u
+ PD=3.68u
M$93 \$34 \$4 \$20 \$2 sg13_lv_pmos L=0.15u W=1.5u AS=0.51p AD=0.51p PS=3.68u
+ PD=3.68u
M$94 \$20 \$8 \$37 \$2 sg13_lv_pmos L=0.15u W=1.5u AS=0.51p AD=0.51p PS=3.68u
+ PD=3.68u
M$95 \$2 \$8 \$4 \$2 sg13_lv_pmos L=0.15u W=1.5u AS=0.51p AD=0.51p PS=3.68u
+ PD=3.68u
M$96 \$47 \$7 \$2 \$2 sg13_lv_pmos L=0.15u W=3u AS=0.795p AD=0.795p PS=5.56u
+ PD=5.56u
M$98 \$2 \$5 \$11 \$2 sg13_lv_pmos L=0.15u W=1.5u AS=0.51p AD=0.51p PS=3.68u
+ PD=3.68u
M$99 \$2 \$74 \$68 \$2 sg13_lv_pmos L=0.15u W=1.5u AS=0.51p AD=0.285p PS=3.68u
+ PD=1.88u
M$100 \$68 \$72 \$2 \$2 sg13_lv_pmos L=0.15u W=1.5u AS=0.285p AD=0.51p PS=1.88u
+ PD=3.68u
M$101 \$2 \$5 \$52 \$2 sg13_lv_pmos L=0.15u W=1.5u AS=0.51p AD=0.285p PS=3.68u
+ PD=1.88u
M$102 \$52 \$46 \$34 \$2 sg13_lv_pmos L=0.15u W=1.5u AS=0.285p AD=0.285p
+ PS=1.88u PD=1.88u
M$103 \$34 \$18 \$53 \$2 sg13_lv_pmos L=0.15u W=1.5u AS=0.285p AD=0.285p
+ PS=1.88u PD=1.88u
M$104 \$53 \$36 \$2 \$2 sg13_lv_pmos L=0.15u W=1.5u AS=0.285p AD=0.51p PS=1.88u
+ PD=3.68u
M$105 \$2 \$68 \$18 \$2 sg13_lv_pmos L=0.15u W=1.5u AS=0.51p AD=0.51p PS=3.68u
+ PD=3.68u
M$106 \$36 \$5 \$2 \$2 sg13_lv_pmos L=0.15u W=1.5u AS=0.51p AD=0.285p PS=3.68u
+ PD=1.88u
M$107 \$2 \$18 \$46 \$2 sg13_lv_pmos L=0.15u W=1.5u AS=0.285p AD=0.51p PS=1.88u
+ PD=3.68u
M$108 \$69 \$73 \$2 \$2 sg13_lv_pmos L=0.15u W=1.5u AS=0.51p AD=0.51p PS=3.68u
+ PD=3.68u
M$109 \$75 \$24 \$2 \$2 sg13_lv_pmos L=0.15u W=3u AS=0.795p AD=0.795p PS=5.56u
+ PD=5.56u
M$111 \$69 \$8 \$70 \$2 sg13_lv_pmos L=0.15u W=1.5u AS=0.51p AD=0.51p PS=3.68u
+ PD=3.68u
M$112 \$74 \$70 \$75 \$2 sg13_lv_pmos L=0.15u W=3u AS=0.795p AD=0.795p PS=5.56u
+ PD=5.56u
M$114 \$98 \$24 \$112 \$2 sg13_lv_pmos L=0.15u W=3u AS=0.795p AD=0.795p
+ PS=5.56u PD=5.56u
M$116 \$70 \$67 \$71 \$2 sg13_lv_pmos L=0.15u W=1.5u AS=0.51p AD=0.51p PS=3.68u
+ PD=3.68u
M$117 \$97 \$67 \$73 \$2 sg13_lv_pmos L=0.15u W=1.5u AS=0.51p AD=0.51p PS=3.68u
+ PD=3.68u
M$118 \$73 \$8 \$98 \$2 sg13_lv_pmos L=0.15u W=1.5u AS=0.51p AD=0.51p PS=3.68u
+ PD=3.68u
M$119 \$2 \$8 \$67 \$2 sg13_lv_pmos L=0.15u W=1.5u AS=0.51p AD=0.51p PS=3.68u
+ PD=3.68u
M$120 \$112 \$69 \$2 \$2 sg13_lv_pmos L=0.15u W=3u AS=0.795p AD=0.795p PS=5.56u
+ PD=5.56u
M$122 \$2 \$74 \$71 \$2 sg13_lv_pmos L=0.15u W=1.5u AS=0.51p AD=0.51p PS=3.68u
+ PD=3.68u
M$123 \$2 \$129 \$130 \$2 sg13_lv_pmos L=0.15u W=1.5u AS=0.51p AD=0.285p
+ PS=3.68u PD=1.88u
M$124 \$130 \$144 \$2 \$2 sg13_lv_pmos L=0.15u W=1.5u AS=0.285p AD=0.51p
+ PS=1.88u PD=3.68u
M$125 \$2 \$74 \$113 \$2 sg13_lv_pmos L=0.15u W=1.5u AS=0.51p AD=0.285p
+ PS=3.68u PD=1.88u
M$126 \$113 \$111 \$97 \$2 sg13_lv_pmos L=0.15u W=1.5u AS=0.285p AD=0.285p
+ PS=1.88u PD=1.88u
M$127 \$97 \$72 \$114 \$2 sg13_lv_pmos L=0.15u W=1.5u AS=0.285p AD=0.285p
+ PS=1.88u PD=1.88u
M$128 \$114 \$96 \$2 \$2 sg13_lv_pmos L=0.15u W=1.5u AS=0.285p AD=0.51p
+ PS=1.88u PD=3.68u
M$129 \$2 \$130 \$72 \$2 sg13_lv_pmos L=0.15u W=1.5u AS=0.51p AD=0.51p PS=3.68u
+ PD=3.68u
M$130 \$96 \$74 \$2 \$2 sg13_lv_pmos L=0.15u W=1.5u AS=0.51p AD=0.285p PS=3.68u
+ PD=1.88u
M$131 \$2 \$72 \$111 \$2 sg13_lv_pmos L=0.15u W=1.5u AS=0.285p AD=0.51p
+ PS=1.88u PD=3.68u
M$132 \$131 \$146 \$2 \$2 sg13_lv_pmos L=0.15u W=1.5u AS=0.51p AD=0.51p
+ PS=3.68u PD=3.68u
M$133 \$134 \$24 \$2 \$2 sg13_lv_pmos L=0.15u W=3u AS=0.795p AD=0.795p PS=5.56u
+ PD=5.56u
M$135 \$131 \$8 \$132 \$2 sg13_lv_pmos L=0.15u W=1.5u AS=0.51p AD=0.51p
+ PS=3.68u PD=3.68u
M$136 \$129 \$132 \$134 \$2 sg13_lv_pmos L=0.15u W=3u AS=0.795p AD=0.795p
+ PS=5.56u PD=5.56u
M$138 \$159 \$24 \$169 \$2 sg13_lv_pmos L=0.15u W=3u AS=0.795p AD=0.795p
+ PS=5.56u PD=5.56u
M$140 \$132 \$128 \$133 \$2 sg13_lv_pmos L=0.15u W=1.5u AS=0.51p AD=0.51p
+ PS=3.68u PD=3.68u
M$141 \$156 \$128 \$146 \$2 sg13_lv_pmos L=0.15u W=1.5u AS=0.51p AD=0.51p
+ PS=3.68u PD=3.68u
M$142 \$146 \$8 \$159 \$2 sg13_lv_pmos L=0.15u W=1.5u AS=0.51p AD=0.51p
+ PS=3.68u PD=3.68u
M$143 \$2 \$8 \$128 \$2 sg13_lv_pmos L=0.15u W=1.5u AS=0.51p AD=0.51p PS=3.68u
+ PD=3.68u
M$144 \$169 \$131 \$2 \$2 sg13_lv_pmos L=0.15u W=3u AS=0.795p AD=0.795p
+ PS=5.56u PD=5.56u
M$146 \$2 \$129 \$133 \$2 sg13_lv_pmos L=0.15u W=1.5u AS=0.51p AD=0.51p
+ PS=3.68u PD=3.68u
M$147 \$2 \$190 \$191 \$2 sg13_lv_pmos L=0.15u W=1.5u AS=0.51p AD=0.285p
+ PS=3.68u PD=1.88u
M$148 \$191 \$202 \$2 \$2 sg13_lv_pmos L=0.15u W=1.5u AS=0.285p AD=0.51p
+ PS=1.88u PD=3.68u
M$149 \$2 \$129 \$174 \$2 sg13_lv_pmos L=0.15u W=1.5u AS=0.51p AD=0.285p
+ PS=3.68u PD=1.88u
M$150 \$174 \$168 \$156 \$2 sg13_lv_pmos L=0.15u W=1.5u AS=0.285p AD=0.285p
+ PS=1.88u PD=1.88u
M$151 \$156 \$144 \$175 \$2 sg13_lv_pmos L=0.15u W=1.5u AS=0.285p AD=0.285p
+ PS=1.88u PD=1.88u
M$152 \$175 \$158 \$2 \$2 sg13_lv_pmos L=0.15u W=1.5u AS=0.285p AD=0.51p
+ PS=1.88u PD=3.68u
M$153 \$2 \$191 \$144 \$2 sg13_lv_pmos L=0.15u W=1.5u AS=0.51p AD=0.51p
+ PS=3.68u PD=3.68u
M$154 \$158 \$129 \$2 \$2 sg13_lv_pmos L=0.15u W=1.5u AS=0.51p AD=0.285p
+ PS=3.68u PD=1.88u
M$155 \$2 \$144 \$168 \$2 sg13_lv_pmos L=0.15u W=1.5u AS=0.285p AD=0.51p
+ PS=1.88u PD=3.68u
M$156 \$192 \$203 \$2 \$2 sg13_lv_pmos L=0.15u W=1.5u AS=0.51p AD=0.51p
+ PS=3.68u PD=3.68u
M$157 \$194 \$24 \$2 \$2 sg13_lv_pmos L=0.15u W=3u AS=0.795p AD=0.795p PS=5.56u
+ PD=5.56u
M$159 \$192 \$8 \$193 \$2 sg13_lv_pmos L=0.15u W=1.5u AS=0.51p AD=0.51p
+ PS=3.68u PD=3.68u
M$160 \$190 \$193 \$194 \$2 sg13_lv_pmos L=0.15u W=3u AS=0.795p AD=0.795p
+ PS=5.56u PD=5.56u
M$162 \$220 \$24 \$229 \$2 sg13_lv_pmos L=0.15u W=3u AS=0.795p AD=0.795p
+ PS=5.56u PD=5.56u
M$164 \$193 \$189 \$195 \$2 sg13_lv_pmos L=0.15u W=1.5u AS=0.51p AD=0.51p
+ PS=3.68u PD=3.68u
M$165 \$217 \$189 \$203 \$2 sg13_lv_pmos L=0.15u W=1.5u AS=0.51p AD=0.51p
+ PS=3.68u PD=3.68u
M$166 \$203 \$8 \$220 \$2 sg13_lv_pmos L=0.15u W=1.5u AS=0.51p AD=0.51p
+ PS=3.68u PD=3.68u
M$167 \$2 \$8 \$189 \$2 sg13_lv_pmos L=0.15u W=1.5u AS=0.51p AD=0.51p PS=3.68u
+ PD=3.68u
M$168 \$229 \$192 \$2 \$2 sg13_lv_pmos L=0.15u W=3u AS=0.795p AD=0.795p
+ PS=5.56u PD=5.56u
M$170 \$2 \$190 \$195 \$2 sg13_lv_pmos L=0.15u W=1.5u AS=0.51p AD=0.51p
+ PS=3.68u PD=3.68u
M$171 \$2 \$190 \$235 \$2 sg13_lv_pmos L=0.15u W=1.5u AS=0.51p AD=0.285p
+ PS=3.68u PD=1.88u
M$172 \$235 \$234 \$217 \$2 sg13_lv_pmos L=0.15u W=1.5u AS=0.285p AD=0.285p
+ PS=1.88u PD=1.88u
M$173 \$217 \$202 \$236 \$2 sg13_lv_pmos L=0.15u W=1.5u AS=0.285p AD=0.285p
+ PS=1.88u PD=1.88u
M$174 \$236 \$219 \$2 \$2 sg13_lv_pmos L=0.15u W=1.5u AS=0.285p AD=0.51p
+ PS=1.88u PD=3.68u
M$175 \$219 \$190 \$2 \$2 sg13_lv_pmos L=0.15u W=1.5u AS=0.51p AD=0.285p
+ PS=3.68u PD=1.88u
M$176 \$2 \$202 \$234 \$2 sg13_lv_pmos L=0.15u W=1.5u AS=0.285p AD=0.51p
+ PS=1.88u PD=3.68u
.ENDS Contador4bits_U
