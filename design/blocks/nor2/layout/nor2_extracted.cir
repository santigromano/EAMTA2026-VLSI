* Extracted by KLayout with SG13G2 LVS runset on : 12/03/2026 19:54

.SUBCKT nor2
M$1 \$4 \$1 \$6 \$4 sg13_lv_pmos L=0.15u W=3u AS=1.02p AD=1.02p PS=6.68u
+ PD=6.68u
M$2 \$6 \$2 \$5 \$4 sg13_lv_pmos L=0.15u W=3u AS=1.02p AD=1.02p PS=6.68u
+ PD=6.68u
M$3 \$3 \$1 \$5 \$3 sg13_lv_nmos L=0.15u W=0.75u AS=0.255p AD=0.255p PS=2.18u
+ PD=2.18u
M$4 \$5 \$2 \$3 \$3 sg13_lv_nmos L=0.15u W=0.75u AS=0.255p AD=0.255p PS=2.18u
+ PD=2.18u
.ENDS nor2
