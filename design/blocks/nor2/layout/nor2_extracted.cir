* Extracted by KLayout with SG13G2 LVS runset on : 12/03/2026 16:08

.SUBCKT nor2
M$1 \$1 \$6 \$5 \$1 sg13_lv_nmos L=0.15u W=0.75u AS=0.255p AD=0.255p PS=2.18u
+ PD=2.18u
M$2 \$5 \$7 \$1 \$1 sg13_lv_nmos L=0.15u W=0.75u AS=0.255p AD=0.255p PS=2.18u
+ PD=2.18u
M$3 \$3 \$6 \$4 \$3 sg13_lv_pmos L=0.15u W=3u AS=1.02p AD=1.02p PS=6.68u
+ PD=6.68u
M$4 \$4 \$7 \$5 \$3 sg13_lv_pmos L=0.15u W=3u AS=1.02p AD=1.02p PS=6.68u
+ PD=6.68u
.ENDS nor2
