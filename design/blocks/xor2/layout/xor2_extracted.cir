* Extracted by KLayout with SG13G2 LVS runset on : 20/03/2026 23:57

.SUBCKT xor2
M$1 \$5 \$14 \$1 \$1 sg13_lv_nmos L=0.15u W=0.75u AS=0.255p AD=0.1425p PS=2.18u
+ PD=1.13u
M$2 \$1 \$13 \$12 \$1 sg13_lv_nmos L=0.15u W=0.75u AS=0.1425p AD=0.255p
+ PS=1.13u PD=2.18u
M$3 \$1 \$14 \$2 \$1 sg13_lv_nmos L=0.15u W=1.5u AS=0.51p AD=0.285p PS=3.68u
+ PD=1.88u
M$4 \$2 \$13 \$3 \$1 sg13_lv_nmos L=0.15u W=1.5u AS=0.285p AD=0.285p PS=1.88u
+ PD=1.88u
M$5 \$3 \$12 \$4 \$1 sg13_lv_nmos L=0.15u W=1.5u AS=0.285p AD=0.285p PS=1.88u
+ PD=1.88u
M$6 \$4 \$5 \$1 \$1 sg13_lv_nmos L=0.15u W=1.5u AS=0.285p AD=0.51p PS=1.88u
+ PD=3.68u
M$7 \$15 \$14 \$16 \$15 sg13_lv_pmos L=0.15u W=1.5u AS=0.51p AD=0.285p PS=3.68u
+ PD=1.88u
M$8 \$16 \$12 \$3 \$15 sg13_lv_pmos L=0.15u W=1.5u AS=0.285p AD=0.285p PS=1.88u
+ PD=1.88u
M$9 \$3 \$13 \$17 \$15 sg13_lv_pmos L=0.15u W=1.5u AS=0.285p AD=0.285p PS=1.88u
+ PD=1.88u
M$10 \$17 \$5 \$15 \$15 sg13_lv_pmos L=0.15u W=1.5u AS=0.285p AD=0.51p PS=1.88u
+ PD=3.68u
M$11 \$5 \$14 \$15 \$15 sg13_lv_pmos L=0.15u W=1.5u AS=0.51p AD=0.285p PS=3.68u
+ PD=1.88u
M$12 \$15 \$13 \$12 \$15 sg13_lv_pmos L=0.15u W=1.5u AS=0.285p AD=0.51p
+ PS=1.88u PD=3.68u
.ENDS xor2
