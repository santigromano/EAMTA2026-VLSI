* Extracted by KLayout with SG13G2 LVS runset on : 28/03/2026 14:08

.SUBCKT Contador1bit_U
X$1 \$7 \$6 \$3 \$2 \$1 xor2
X$2 \$6 \$7 \$12 \$2 \$11 \$1 dffc
M$1 \$6 \$2 \$I3 \$6 sg13_lv_nmos L=0.15u W=1.5u AS=0.51p AD=0.285p PS=3.68u
+ PD=1.88u
M$2 \$I3 \$3 \$I2 \$6 sg13_lv_nmos L=0.15u W=1.5u AS=0.285p AD=0.51p PS=1.88u
+ PD=3.68u
M$3 \$7 \$I2 \$4 \$7 sg13_lv_pmos L=0.15u W=1.5u AS=0.51p AD=0.51p PS=3.68u
+ PD=3.68u
M$4 \$7 \$2 \$I2 \$7 sg13_lv_pmos L=0.15u W=1.5u AS=0.51p AD=0.285p PS=3.68u
+ PD=1.88u
M$5 \$I2 \$3 \$7 \$7 sg13_lv_pmos L=0.15u W=1.5u AS=0.285p AD=0.51p PS=1.88u
+ PD=3.68u
M$6 \$6 \$I2 \$4 \$6 sg13_lv_nmos L=0.15u W=0.75u AS=0.255p AD=0.255p PS=2.18u
+ PD=2.18u
.ENDS Contador1bit_U

.SUBCKT dffc \$1 \$2 \$4 \$7 \$8 \$15
M$1 \$1 \$8 \$7 \$1 sg13_lv_nmos L=0.15u W=0.75u AS=0.255p AD=0.1425p PS=2.18u
+ PD=1.13u
M$2 \$7 \$6 \$1 \$1 sg13_lv_nmos L=0.15u W=0.75u AS=0.1425p AD=0.255p PS=1.13u
+ PD=2.18u
M$3 \$1 \$5 \$17 \$1 sg13_lv_nmos L=0.15u W=0.75u AS=0.255p AD=0.1425p PS=2.18u
+ PD=1.13u
M$4 \$17 \$8 \$1 \$1 sg13_lv_nmos L=0.15u W=0.75u AS=0.1425p AD=0.255p PS=1.13u
+ PD=2.18u
M$5 \$12 \$3 \$17 \$1 sg13_lv_nmos L=0.15u W=0.75u AS=0.255p AD=0.255p PS=2.18u
+ PD=2.18u
M$6 \$12 \$4 \$17 \$2 sg13_lv_pmos L=0.15u W=1.5u AS=0.51p AD=0.51p PS=3.68u
+ PD=3.68u
M$7 \$I6 \$8 \$2 \$2 sg13_lv_pmos L=0.15u W=3u AS=0.795p AD=0.795p PS=5.56u
+ PD=5.56u
M$9 \$7 \$6 \$I6 \$2 sg13_lv_pmos L=0.15u W=3u AS=0.795p AD=0.795p PS=5.56u
+ PD=5.56u
M$11 \$5 \$3 \$6 \$1 sg13_lv_nmos L=0.15u W=0.75u AS=0.255p AD=0.255p PS=2.18u
+ PD=2.18u
M$12 \$5 \$4 \$6 \$2 sg13_lv_pmos L=0.15u W=1.5u AS=0.51p AD=0.51p PS=3.68u
+ PD=3.68u
M$13 \$2 \$12 \$5 \$2 sg13_lv_pmos L=0.15u W=1.5u AS=0.51p AD=0.51p PS=3.68u
+ PD=3.68u
M$14 \$1 \$12 \$5 \$1 sg13_lv_nmos L=0.15u W=0.75u AS=0.255p AD=0.255p PS=2.18u
+ PD=2.18u
M$15 \$15 \$4 \$12 \$1 sg13_lv_nmos L=0.15u W=0.75u AS=0.255p AD=0.255p
+ PS=2.18u PD=2.18u
M$16 \$15 \$3 \$12 \$2 sg13_lv_pmos L=0.15u W=1.5u AS=0.51p AD=0.51p PS=3.68u
+ PD=3.68u
M$17 \$2 \$7 \$11 \$2 sg13_lv_pmos L=0.15u W=1.5u AS=0.51p AD=0.51p PS=3.68u
+ PD=3.68u
M$18 \$1 \$7 \$11 \$1 sg13_lv_nmos L=0.15u W=0.75u AS=0.255p AD=0.255p PS=2.18u
+ PD=2.18u
M$19 \$2 \$4 \$3 \$2 sg13_lv_pmos L=0.15u W=1.5u AS=0.51p AD=0.51p PS=3.68u
+ PD=3.68u
M$20 \$1 \$4 \$3 \$1 sg13_lv_nmos L=0.15u W=0.75u AS=0.255p AD=0.255p PS=2.18u
+ PD=2.18u
M$21 \$6 \$4 \$11 \$1 sg13_lv_nmos L=0.15u W=0.75u AS=0.255p AD=0.255p PS=2.18u
+ PD=2.18u
M$22 \$6 \$3 \$11 \$2 sg13_lv_pmos L=0.15u W=1.5u AS=0.51p AD=0.51p PS=3.68u
+ PD=3.68u
M$23 \$I7 \$5 \$2 \$2 sg13_lv_pmos L=0.15u W=3u AS=0.795p AD=0.795p PS=5.56u
+ PD=5.56u
M$25 \$17 \$8 \$I7 \$2 sg13_lv_pmos L=0.15u W=3u AS=0.795p AD=0.795p PS=5.56u
+ PD=5.56u
.ENDS dffc

.SUBCKT xor2 \$1 \$2 \$4 \$6 \$7
M$1 \$2 \$6 \$15 \$2 sg13_lv_nmos L=0.15u W=1.5u AS=0.51p AD=0.285p PS=3.68u
+ PD=1.88u
M$2 \$15 \$4 \$7 \$2 sg13_lv_nmos L=0.15u W=1.5u AS=0.285p AD=0.285p PS=1.88u
+ PD=1.88u
M$3 \$7 \$5 \$9 \$2 sg13_lv_nmos L=0.15u W=1.5u AS=0.285p AD=0.285p PS=1.88u
+ PD=1.88u
M$4 \$9 \$3 \$2 \$2 sg13_lv_nmos L=0.15u W=1.5u AS=0.285p AD=0.51p PS=1.88u
+ PD=3.68u
M$5 \$3 \$6 \$2 \$2 sg13_lv_nmos L=0.15u W=0.75u AS=0.255p AD=0.1425p PS=2.18u
+ PD=1.13u
M$6 \$2 \$4 \$5 \$2 sg13_lv_nmos L=0.15u W=0.75u AS=0.1425p AD=0.255p PS=1.13u
+ PD=2.18u
M$7 \$3 \$6 \$1 \$1 sg13_lv_pmos L=0.15u W=1.5u AS=0.51p AD=0.285p PS=3.68u
+ PD=1.88u
M$8 \$1 \$4 \$5 \$1 sg13_lv_pmos L=0.15u W=1.5u AS=0.285p AD=0.51p PS=1.88u
+ PD=3.68u
M$9 \$1 \$6 \$23 \$1 sg13_lv_pmos L=0.15u W=1.5u AS=0.51p AD=0.285p PS=3.68u
+ PD=1.88u
M$10 \$23 \$5 \$7 \$1 sg13_lv_pmos L=0.15u W=1.5u AS=0.285p AD=0.285p PS=1.88u
+ PD=1.88u
M$11 \$7 \$4 \$20 \$1 sg13_lv_pmos L=0.15u W=1.5u AS=0.285p AD=0.285p PS=1.88u
+ PD=1.88u
M$12 \$20 \$3 \$1 \$1 sg13_lv_pmos L=0.15u W=1.5u AS=0.285p AD=0.51p PS=1.88u
+ PD=3.68u
.ENDS xor2
